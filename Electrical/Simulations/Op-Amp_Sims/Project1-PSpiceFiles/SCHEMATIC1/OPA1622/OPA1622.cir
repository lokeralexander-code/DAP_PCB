** Profile: "SCHEMATIC1-OPA1622"  [ C:\Users\loker\Projects\DAP_PCB\Electrical\Op-Amp_Sims\Project1-PSpiceFiles\SCHEMATIC1\OPA1622.sim ]

** Creating circuit file "OPA1622.cir"
** WARNING: THIS AUTOMATICALLY GENERATED FILE MAY BE OVERWRITTEN BY SUBSEQUENT SIMULATIONS

*Libraries:
* Profile Libraries :
* Local Libraries :
* From [PSPICE NETLIST] section of C:\cds_spb_home\cdssetup\OrCAD_PSpiceTIPSpice_Install\23.1.0\PSpice.ini file:
.lib "nom_pspti.lib"
.lib "nom.lib"

*Analysis directives:
.TRAN  0 20u 0 1n
.STEP PARAM Cl LIST 300p 600p 1n
.OPTIONS ADVCONV
.OPTIONS FILEMODELSEARCH
.PROBE64 V(alias(*)) I(alias(*)) W(alias(*)) D(alias(*)) NOISE(alias(*))
.INC "..\SCHEMATIC1.net"

.END
